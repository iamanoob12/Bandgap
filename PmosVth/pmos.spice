.lib "$PDK_ROOT/sky130A/libs.tech/ngspice/sky130.lib.spice" tt

* Apply DC bias voltages for PFET (Vsg = -1.8V, Vsd = -1.8V)
Vdd Vdd 0 DC -1.8
Vsg Vsg 0 DC -1.8
Xp1 0 Vsg Vdd 0 MY_PFET W_val=5 L_val=0.30

.subckt MY_PFET Vs Vg Vd Vb W_val=5 L_val=0.30
   XMP Vd Vg Vs Vb sky130_fd_pr__pfet_01v8 w='W_val' l='L_val' nf=1 ad=1.45 as=1.45 pd=10.58 ps=10.58 nrd=0.058 nrs=0.058 sa=0 sb=0 sd=0 mult=1
.ends MY_PFET

.control
    let init_temp = -45
    echo "T,vth" > pmos_vth_temp.csv
    while init_temp <= 125
        options temp = $&init_temp
        op
        let vth = @m.xp1.xmp.msky130_fd_pr__pfet_01v8[vth]
        echo "$&init_temp,$&vth" >> pmos_vth_temp.csv
        let init_temp = init_temp + 1
        reset
    end

.endc

.end

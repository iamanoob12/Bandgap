*** Pmos Low temp ***

.lib "$PDK_ROOT/sky130A/libs.tech/ngspice/sky130.lib.spice" tt

*** Bias ***
Vs Vs 0 DC 0
Vd Vd 0 DC 0
Vg Vg 0 DC -1.662
Vb Vb 0 DC 0

XP Vs Vg Vd Vb MY_PFET W_val=0.75 L_val=0.30

.subckt MY_NFET Vd Vg Vs Vb W_val=5 L_val=0.15 mult=1
    XMN Vd Vg Vs Vb sky130_fd_pr__nfet_01v8 w='W_val' l='L_val' nf=1 ad=1.45 as=1.45 pd=10.58 ps=10.58 nrd=0.058 nrs=0.058 sa=0 sb=0 sd=0 mult='mult'
.ends MY_NFET

.subckt MY_PFET Vs Vg Vd Vb W_val=5 L_val=0.30 mult=1
    XMP Vd Vg Vs Vb sky130_fd_pr__pfet_01v8 w='W_val' l='L_val' nf=1 ad=1.45 as=1.45 pd=10.58 ps=10.58 nrd=0.058 nrs=0.058 sa=0 sb=0 sd=0 mult='mult'
.ends MY_PFET

.control
    options temp=-40, tnom=-40
    op
    print @m.xp.xmp.msky130_fd_pr__pfet_01v8[id]
    print @m.xp.xmp.msky130_fd_pr__pfet_01v8[vth]
    print @m.xp.xmp.msky130_fd_pr__pfet_01v8[vdsat]

    dc Vd 0 -1.8 -0.01
    plot vs#branch

.endc
